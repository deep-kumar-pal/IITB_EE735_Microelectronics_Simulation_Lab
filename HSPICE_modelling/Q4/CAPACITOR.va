`include "disciplines.vams"
module simple_capacitor(p,n) ;
inout p,n ;
electrical p,n ;
parameter real capacitance = 1e-6 from (0.0:inf) ;
real q ;
analog begin
 q = capacitance * V(p,n) ;
 I(p,n) <+ ddt(q) ;
end
endmodule
