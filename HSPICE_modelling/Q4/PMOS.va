`include "disciplines.vams"
`include "constants.vams"
module simple_PMOS(d,g,s,b);
electrical d ,g ,s ,b ; //input-output nodes
parameter real W=1e-5 from [0:inf]; // width of MOSFET
parameter real L=1e-5 from [0:inf]; // Length of MOSFET
parameter real Vth=-0.6 from [-10:inf]; // Threshold voltage
parameter real mu=350 from [0:inf]; // Electron mobility in cm^2 per Volt-sec
parameter real TOX=20e-7 from [0:inf]; // Oxide Thickness
parameter real EP_OX=3.9*8.85e-14 from [0:inf]; // Permittivity of oxide
parameter real EP_SI=11.7*8.85e-14 from [0:inf]; // Permittivity of Silicon
//... PMOS I-V Relation ...//
real Id, Vsg, Vsd;
 analog begin
  Vsg = V(s,g);
  Vsd = V(s,d);
  if (Vsg < abs(Vth))
    Id = 0; // Cut-off region
  else if ((Vsg >= abs(Vth)) && (Vsg - abs(Vth) >= Vsd))
    Id = 0.5*mu*(EP_OX/TOX)*(W/L)*(2*(Vsg-abs(Vth))*Vsd-Vsd*Vsd); // Linear region
  else if ((Vsg >= abs(Vth)) && (Vsg - abs(Vth) < Vsd))
    Id = 0.5*mu*(EP_OX/TOX)*(W/L)*(Vsg-abs(Vth))*(Vsg-abs(Vth)); // Saturation region
  I(s,d) <+ Id;
 end
endmodule
